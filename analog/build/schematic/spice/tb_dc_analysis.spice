** sch_path: /workspace/analog/build/schematic/tb_dc_analysis.sch
**.subckt tb_dc_analysis
VSS net1 GND 0
VDD net2 GND 1.8
VDIFF net4 net3 0
R1 net3 net5 1M m=1
R2 net4 net5 1M m=1
VCM net5 GND 0.9
x1 net2 vout net3 net4 net1 opamp_two_stage
**** begin user architecture code

.param mc_mm_switch=0
.param mc_pr_switch=0
.include /root/.volare/sky130A/libs.tech/ngspice/corners/tt.spice
.include /root/.volare/sky130A/libs.tech/ngspice/r+c/res_typical__cap_typical.spice
.include /root/.volare/sky130A/libs.tech/ngspice/r+c/res_typical__cap_typical__lin.spice
.include /root/.volare/sky130A/libs.tech/ngspice/corners/tt/specialized_cells.spice

.control

* Sweep differential input from -10 mV to +10 mV
dc VDIFF -0.03 0.01 0.0001

* Measure output around +/-1 mV differential input
meas dc vout_m1 FIND v(vout) AT=-0.001
meas dc vout_p1 FIND v(vout) AT=0.001

* Differential voltage gain
let gain_vv = (vout_p1 - vout_m1)/0.002
let gain_db = 20*log10(abs(gain_vv))

* Input offset:
* find VDIFF where output is at mid-supply = 0.9 V
meas dc input_offset FIND v-sweep WHEN v(vout)=0.9

* Supply current at VDIFF = 0
meas dc idd FIND i(VDD) AT=0

* Power consumption
let power_w = 1.8*abs(idd)
let power_mw = power_w*1000

print gain_vv
print gain_db
print input_offset
print idd
print power_mw

plot v(vout)

.endc

**** end user architecture code
**.ends

* expanding   symbol:  opamp_two_stage.sym # of pins=5
** sym_path: /workspace/analog/build/schematic/opamp_two_stage.sym
** sch_path: /workspace/analog/build/schematic/opamp_two_stage.sch
.subckt opamp_two_stage VDD VOUT VIN_N VIN_P VSS
*.ipin VIN_N
*.ipin VIN_P
*.opin VOUT
*.ipin VDD
*.ipin VSS
XM1 net3 VIN_N net1 VSS sky130_fd_pr__nfet_01v8 L=1 W=10 nf=1 ad='int((nf+1)/2) * W/nf * 0.29' as='int((nf+2)/2) * W/nf * 0.29' pd='2*int((nf+1)/2) * (W/nf + 0.29)'
+ ps='2*int((nf+2)/2) * (W/nf + 0.29)' nrd='0.29 / W' nrs='0.29 / W' sa=0 sb=0 sd=0 mult=1 m=1
XM2 net2 VIN_P net1 VSS sky130_fd_pr__nfet_01v8 L=1 W=10 nf=1 ad='int((nf+1)/2) * W/nf * 0.29' as='int((nf+2)/2) * W/nf * 0.29' pd='2*int((nf+1)/2) * (W/nf + 0.29)'
+ ps='2*int((nf+2)/2) * (W/nf + 0.29)' nrd='0.29 / W' nrs='0.29 / W' sa=0 sb=0 sd=0 mult=1 m=1
XM3 net1 net5 VSS VSS sky130_fd_pr__nfet_01v8 L=2 W=10 nf=1 ad='int((nf+1)/2) * W/nf * 0.29' as='int((nf+2)/2) * W/nf * 0.29' pd='2*int((nf+1)/2) * (W/nf + 0.29)'
+ ps='2*int((nf+2)/2) * (W/nf + 0.29)' nrd='0.29 / W' nrs='0.29 / W' sa=0 sb=0 sd=0 mult=1 m=1
XM4 net3 net2 VDD VDD sky130_fd_pr__pfet_01v8 L=1 W=20 nf=1 ad='int((nf+1)/2) * W/nf * 0.29' as='int((nf+2)/2) * W/nf * 0.29' pd='2*int((nf+1)/2) * (W/nf + 0.29)'
+ ps='2*int((nf+2)/2) * (W/nf + 0.29)' nrd='0.29 / W' nrs='0.29 / W' sa=0 sb=0 sd=0 mult=1 m=1
XM5 net2 net2 VDD VDD sky130_fd_pr__pfet_01v8 L=1 W=20 nf=1 ad='int((nf+1)/2) * W/nf * 0.29' as='int((nf+2)/2) * W/nf * 0.29' pd='2*int((nf+1)/2) * (W/nf + 0.29)'
+ ps='2*int((nf+2)/2) * (W/nf + 0.29)' nrd='0.29 / W' nrs='0.29 / W' sa=0 sb=0 sd=0 mult=1 m=1
XM7 VOUT net5 VSS VSS sky130_fd_pr__nfet_01v8 L=2 W=10 nf=1 ad='int((nf+1)/2) * W/nf * 0.29' as='int((nf+2)/2) * W/nf * 0.29' pd='2*int((nf+1)/2) * (W/nf + 0.29)'
+ ps='2*int((nf+2)/2) * (W/nf + 0.29)' nrd='0.29 / W' nrs='0.29 / W' sa=0 sb=0 sd=0 mult=1 m=1
XM8 VOUT net3 VDD VDD sky130_fd_pr__pfet_01v8 L=1 W=20 nf=1 ad='int((nf+1)/2) * W/nf * 0.29' as='int((nf+2)/2) * W/nf * 0.29' pd='2*int((nf+1)/2) * (W/nf + 0.29)'
+ ps='2*int((nf+2)/2) * (W/nf + 0.29)' nrd='0.29 / W' nrs='0.29 / W' sa=0 sb=0 sd=0 mult=1 m=1
C1 net3 net4 1p m=1
R1 VOUT net4 2k m=1
XM_bias net5 net5 VSS VSS sky130_fd_pr__nfet_01v8 L=2 W=10 nf=1 ad='int((nf+1)/2) * W/nf * 0.29' as='int((nf+2)/2) * W/nf * 0.29' pd='2*int((nf+1)/2) * (W/nf + 0.29)'
+ ps='2*int((nf+2)/2) * (W/nf + 0.29)' nrd='0.29 / W' nrs='0.29 / W' sa=0 sb=0 sd=0 mult=1 m=1
R2 VDD net5 10k m=1
.ends

.GLOBAL GND
.end
